ADE simulation setup
Run mode: Single Run, Sweeps and Corners
Tests:
  LDO:folded_testbench:1: LDO/folded_testbench/schematic, simulator spectre
Global variables:
  CL = 3p
  IREF = 162u
  VCASCN = 1.22
  VCASCP = 1.932
  VDD = 3
  VDD_AC = 0
  VICM = 825m
  VICM_AC = 0
  VID_AC = 1
  VID_DC = 0
