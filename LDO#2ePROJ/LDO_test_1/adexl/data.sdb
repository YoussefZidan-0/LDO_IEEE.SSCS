ADE simulation setup
Run mode: Single Run, Sweeps and Corners
Tests:
  LDO:LDO_test_1:1: LDO/LDO_test_1/schematic, simulator spectre
    Outputs: OP("/NM0" "ids"); gm; OP("/NM0" "vgs"); OP("/NM0" "cgg"); OP("/NM0" "cds"); OP("/NM0" "csd"); OP("/NM0" "csb"); OP("/M0" "ids"); OP("/M0" "vgs"); OP("/M0" "cgg"); OP("/M0" "cds"); OP("/M0" "csd"); OP("/M0" "csb"); Vout_t; dB20(VF("/VOUT")); Vout; FOM
Global variables:
  Cout = 1p
  ILOAD = {From/To}Auto:0.1m::150m{From/To}
  Rout = 10k
  VIN = {From/To}Auto:2.4::3.5{From/To}
  VREF = 0.85
  GM = 100m
  NF = 150
  L = 150n
  W = 10u
  Av = 125
  Cc = 4p
  C_F = 7p
  Av2 = 20
  Rou2t = 0
  Rout2 = 100
  W_SMALL = 10u
  VBAIS = 1
  VBAISN = 0.715
  VCASCN = 1.53
  Rz = 750
  b0 = 2.4
  b1 = 2.4
  b2 = 2.4
  b3 = 2.4
  b4 = 2.4
  L_DAC = 150n
  W_DAC = 10u
  IREF = 170u
  LN = 400n
  LN2 = LN
  LP = 150n
  MN = 4
  MP = 8
  WN = 20u
  WN2 = 20u
  WP = 30u
  LCASCN = 150n
  LP2 = 4u
  WCASCN = 2u
  WP2 = 100u
