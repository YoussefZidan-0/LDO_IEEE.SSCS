ADE simulation setup
Run mode: Single Run, Sweeps and Corners
Tests:
  LDO:test_bench_pmos:1: LDO/test_bench_pmos/schematic, simulator spectre
Global variables:
  L = 400n
  VDS = 3
  VGS = 2.2
  VSB = 0
  W = 10*L
  NF = 56
