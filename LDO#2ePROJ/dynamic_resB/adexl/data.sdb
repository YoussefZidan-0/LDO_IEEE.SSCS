ADE simulation setup
Run mode: Single Run, Sweeps and Corners
Tests:
  LDO.PROJ:dynamic_resB:1: LDO.PROJ/dynamic_resB/schematic, simulator spectre
Global variables:
  Ib = 10u
