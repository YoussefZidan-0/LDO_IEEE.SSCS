ADE simulation setup
Run mode: Single Run, Sweeps and Corners
Tests:
  LDO:resistor_dac:1: LDO/resistor_dac/schematic, simulator spectre
Global variables:
  b4 = 0
  L = 150n
  W = 10u
  b0 = 0
  b1 = 0
  b2 = 0
  b3 = 0
  VREF = 0.85
  IREF = 10u
