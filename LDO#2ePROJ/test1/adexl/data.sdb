ADE simulation setup
Run mode: Single Run, Sweeps and Corners
Tests:
  LDO:test1:1: LDO/test1/schematic, simulator spectre
Global variables:
  VDS = 2.4
  VGS = 500m
  vdd_ac = 1
  VIN = 0
  IREF = 100u
  LN = 500n
  LP = 150n
  WN = 20u
  WP = 10u
  WP2 = 80u
  VOCM = 2.2
  CL = 3p
  VICM = 0.825
  VICM_AC = 0
  VID = 0
  LN2 = LN
  WN2 = 20u
  MN = 4
  MP = 8
  CC = 0
  Rvdd = 0
  VREF = 0.85
  LP2 = 10u
  LCASCN = 150n
  VCASCN = 1.5
  WCASCN = 3u
